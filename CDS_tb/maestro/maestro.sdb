ADE simulation setup
Run mode: Single Run, Sweeps and Corners
Tests:
  ECE4530_Final_Project_CDS_tb_1: ECE4530_Final_Project/CDS_tb/schematic, simulator spectre
    Variables: k = 1; n = 1; m = 20; C_samp = 2p
