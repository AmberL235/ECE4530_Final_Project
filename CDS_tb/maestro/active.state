ADE simulation setup
Test ECE4530_Final_Project_CDS_tb_1: ECE4530_Final_Project/CDS_tb/schematic, simulator spectre
  Models: /opt/cadence-designkits/gpdk045_v_6_0/gpdk045/../models/spectre/gpdk045.scs[mc]
  Variables: C_samp = 2p; k = 1; n = 1; m = 20
  Temperature: 27
  Analysis ac: start=10k stop=1G dec=20
  Analysis dc: (saves the operating point)
  Analysis tran: stop=5u errpreset=conservative
Run mode: Single Run, Sweeps and Corners
