ADE simulation setup
Test lab3_lab3_test_1: ECE4530_Final_Project/diff_amp_tb/schematic, simulator spectre
  Models: /opt/cadence-designkits/gpdk045_v_6_0/gpdk045/../models/spectre/gpdk045.scs[mc]
  Variables: Vb1 = 1.6
  Temperature: 27
  Analysis ac: start=10k stop=1G dec=20
  Analysis dc: (saves the operating point)
Run mode: Single Run, Sweeps and Corners
