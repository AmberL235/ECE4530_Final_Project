ADE simulation setup
Run mode: Single Run, Sweeps and Corners
Tests:
  lab3_lab3_test_1: ECE4530_Final_Project/diff_amp_tb/schematic, simulator spectre
    Variables: Vb1 = 1.6
