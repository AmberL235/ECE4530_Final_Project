ADE simulation setup
Test ECE4530_Final_Project_levelshift-test_1: ECE4530_Final_Project/levelshift_test/schematic, simulator spectre
  Models: /opt/cadence-designkits/gpdk045_v_6_0/gpdk045/../models/spectre/gpdk045.scs[mc]
  Variables: W = 120n; RL = 1G; vhigh = 3.3; vlow = 1
  Temperature: 27
  Analysis dc: sweep W start=120n stop=2u (saves the operating point)
Run mode: Single Run, Sweeps and Corners
