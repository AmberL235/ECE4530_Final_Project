ADE simulation setup
Test ECE4530_Final_Project_levelshift-test_1: ECE4530_Final_Project/levelshift_test/schematic, simulator spectre
  Models: /opt/cadence-designkits/gpdk045_v_6_0/gpdk045/../models/spectre/gpdk045.scs[mc]
  Temperature: 27
  Analysis ac: start=10k stop=1G
  Analysis tran: stop=5n
  Analysis dc: (saves the operating point)
Run mode: Single Run, Sweeps and Corners
