ADE simulation setup
Test ECE4530_Final_Project_levelshift-test_1: ECE4530_Final_Project/levelshift_test/schematic, simulator spectre
  Models: /opt/cadence-designkits/gpdk045_v_6_0/gpdk045/../models/spectre/gpdk045.scs[mc]
  Variables: RL = 1G; vhigh = 3.3; vlow = 1; Wn = 120n; Wp = 120n
  Temperature: 27
  Analysis tran: stop=1u
  Analysis dc: (saves the operating point)
Run mode: Single Run, Sweeps and Corners
