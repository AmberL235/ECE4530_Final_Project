ADE simulation setup
Test ECE4530_Final_Project_levelshift-test_1: ECE4530_Final_Project/levelshift_test/schematic, simulator spectre
  Models: /opt/cadence-designkits/gpdk045_v_6_0/gpdk045/../models/spectre/gpdk045.scs[mc]
  Variables: Wp = 120n; Wn = 1u; RL = 100M; vhigh = 3.3; vlow = 1
  Temperature: 27
  Analysis dc: (saves the operating point)
  Analysis tran: stop=5n
  Analysis ac: start=10k stop=1G
Run mode: Single Run, Sweeps and Corners
