ADE simulation setup
Run mode: Single Run, Sweeps and Corners
Tests:
  ECE4530_Final_Project_levelshift-test_1: ECE4530_Final_Project/levelshift_test/schematic, simulator spectre
    Variables: RL = 1G; vhigh = 3.3; vlow = 1; Wn = 120n; Wp = 120n
