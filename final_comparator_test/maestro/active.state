ADE simulation setup
Test labs_final_comparator_test_1: labs/final_comparator_test/schematic, simulator spectre
  Models: /opt/cadence-designkits/gpdk045_v_6_0/gpdk045/../models/spectre/gpdk045.scs[mc]
  Temperature: 27
  Analysis dc: (saves the operating point)
  Analysis tran: stop=30u errpreset=conservative
Run mode: Single Run, Sweeps and Corners
