ADE simulation setup
Run mode: Single Run, Sweeps and Corners
Tests:
  labs_final_comparator_test_1: labs/final_comparator_test/schematic, simulator spectre
