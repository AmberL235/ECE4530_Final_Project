ADE simulation setup
Test ECE4740_S25_lab2_tb_1: ECE4740_S25_lab2/lab2_tb/config, simulator spectre
  Models: /opt/cadence-designkits/gpdk045_v_6_0/gpdk045/../models/spectre/gpdk045.scs[mc]
  Variables: reset = 0; set = 0; tr = 10p; Tena = .2n; Tper = 2n; vdd = 1; Tclk = Tper
  Temperature: 27
  Simulator options: tnom=25
  Analysis tran: stop=32*VAR("Tper") errpreset=conservative
  Signals: /out<31:0>, /ena, /A<4:0>, /Q<4:0>
Run mode: Single Run, Sweeps and Corners
