ADE simulation setup
Run mode: Single Run, Sweeps and Corners
Tests:
  ECE4740_S25_lab2_tb_1: ECE4740_S25_lab2/lab2_tb/config, simulator spectre
    Variables: Tclk = Tper; Tena = .2n; Tper = 2n; vdd = 1; reset = 0; set = 0; tr = 10p
    Outputs: /Q<4:0>
