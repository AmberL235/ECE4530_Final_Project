ADE simulation setup
Test labs_final_ADC_test_1: labs/final_ADC_test/schematic, simulator spectre
  Models: /opt/cadence-designkits/gpdk045_v_6_0/gpdk045/../models/spectre/gpdk045.scs[mc]
  Variables: V_REF = 1.5; C = 1p
  Temperature: 27
  Analysis tran: stop=400u errpreset=conservative
  Output ((value(vtime('tran "/B0") 2.9e-05 ?period 3e-05 ?xName "time") + (value(vtime('tran "/B1") 2.9e-05 ?period 3e-05 ?xName "time") * 2) + (value(vtime('tran "/B2") 2.9e-05 ?period 3e-05 ?xName "time") * 4) + (value(vtime('tran "/B3") 2.9e-05 ?period 3e-05 ?xName "time") * 8)) / 3)
Run mode: Single Run, Sweeps and Corners
