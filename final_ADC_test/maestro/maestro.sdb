ADE simulation setup
Run mode: Single Run, Sweeps and Corners
Tests:
  labs_final_ADC_test_1: labs/final_ADC_test/schematic, simulator spectre
    Variables: C = 1p; V_REF = 1.5
