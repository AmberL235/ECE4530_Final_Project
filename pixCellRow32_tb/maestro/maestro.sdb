ADE simulation setup
Run mode: Single Run, Sweeps and Corners
Tests:
  final_proj_pixCellRow32_tb_1: final_proj/pixCellRow32_tb/schematic, simulator spectre
    Variables: vwidth = 50n; row_width = 100n; rst_pd = 300n; rst_delay = 0; tx_delay = 100n; tx_pd = 300n; row_pd = 50n; row_delay = 60n; vdd = 3.3; vrst = 3.3; ibias1 = 1p; ibias2 = 2p; ibias3 = 3p; ibias4 = 5p; ibias5 = 30p; ibias6 = 75p; ibias7 = 1n; ibias8 = 10n; CDi = 1u
