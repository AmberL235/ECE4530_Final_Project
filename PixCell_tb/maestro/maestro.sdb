ADE simulation setup
Run mode: Single Run, Sweeps and Corners
Tests:
  final_proj_PixCell_tb_1: final_proj/PixCell_tb/schematic, simulator spectre
    Variables: vwidth = 5p; row_width = 50p; rst_pd = 50p; rst_delay = 0; tx_delay = 75p; tx_pd = 75p; row_pd = 50p; row_delay = 60p; vdd = 3.3; vrst = 3.3; ibias = 20p:200p:1n
