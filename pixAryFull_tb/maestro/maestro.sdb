ADE simulation setup
Run mode: Single Run, Sweeps and Corners
Tests:
  final_proj_pixCellRow32_tb_1: ECE4530_Final_Project/pixCellRow32_tb/schematic, simulator spectre
