ADE simulation setup
Run mode: Single Run, Sweeps and Corners
Tests:
  final_proj_pixCellRow32_tb_1: ECE4530_Final_Project/pixAryFull_tb/schematic, simulator spectre
    Variables: vwidth = 50n; row_width = 75n; rst_pd = 250n; rst_delay = 0; tx_delay = 120n; tx_pd = 250n; row_pd = 250n; row_delay = 60n; vdd = 3.3; vrst = 3.3; ibias1 = 1p; ibias2 = 2p; ibias3 = 3p; ibias4 = 5p; ibias5 = 30p; ibias6 = 75p; ibias7 = 1n; ibias8 = 10n; CDi = 1u; Wn = 1u; Wp = 120n; C_samp = 2p; calc_signal_delay = 180n; calc_signal_pd = 250n; sample_reset_delay = 60n; sample_reset_pd = 250n
