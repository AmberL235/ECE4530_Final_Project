ADE simulation setup
Test final_proj_pixCellRow32_tb_1: ECE4530_Final_Project/pixAryFull_tb/schematic, simulator spectre
  Models: /opt/cadence-designkits/gpdk045_v_6_0/gpdk045/../models/spectre/gpdk045.scs[mc]
  Variables: calc_signal_delay = 180n; calc_signal_pd = 250n; sample_reset_delay = 60n; sample_reset_pd = 250n; C_samp = 2p; Wn = 1u; Wp = 120n; vwidth = 50n; row_width = 75n; rst_pd = 250n; rst_delay = 0; tx_delay = 120n; tx_pd = 250n; row_pd = 250n; row_delay = 60n; vdd = 3.3; vrst = 3.3; ibias1 = 1p; ibias2 = 2p; ibias3 = 3p; ibias4 = 5p; ibias5 = 30p; ibias6 = 75p; ibias7 = 1n; ibias8 = 10n; CDi = 1u
  Temperature: 27.0
  Analysis dc: (saves the operating point)
  Analysis tran: stop=1u errpreset=conservative
Run mode: Single Run, Sweeps and Corners
Setup values for test final_proj_pixCellRow32_tb_1: rst_pd = 300n; tx_delay = 75n; tx_pd = 300n; row_pd = 300n
