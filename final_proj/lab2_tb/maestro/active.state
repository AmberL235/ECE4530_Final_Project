ADE simulation setup
Test ECE4740_S25_lab2_tb_1: final_proj/lab2_tb/config, simulator spectre
  Models: /opt/cadence-designkits/gpdk045_v_6_0/gpdk045/../models/spectre/gpdk045.scs[mc]
  Variables: reset = 0; set = 0; tr = 10p; Tena = 0.2n; Tper = 2n; vdd = 1; tdelay = 5n; Tclk = Tper
  Temperature: 27
  Simulator options: tnom=25
  Analysis tran: stop=64n errpreset=conservative
  Signals: /ena, /A<4:0>
Run mode: Single Run, Sweeps and Corners
