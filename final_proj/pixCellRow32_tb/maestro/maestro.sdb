ADE simulation setup
Run mode: Single Run, Sweeps and Corners
Tests:
  final_proj_pixCellRow32_tb_1: final_proj/pixCellRow32_tb/schematic, simulator spectre
    Variables: vwidth = 50n; row_width = 100n; rst_pd = 300n; rst_delay = 0; tx_delay = 100n; tx_pd = 300n; row_pd = 50n; row_delay = 60n; vdd = 1; vrst = 3.3; ibias1 = 1p; ibias2 = 2p; ibias3 = 3p; ibias4 = 5p; ibias5 = 30p; ibias6 = 75p; ibias7 = 1n; ibias8 = 10n; CDi = 100n; tclk = 15n; Tena = 2n; vdd2 = 3.3; reset = 0; set = 0; tr = 10p; Tper = 2n; Tclk = 10n; Tdelay = 3.5n; rowdelay = 4.5n; TenaRow = 2n; W = 120n; VDDH = 3.3; VDDL = 1
