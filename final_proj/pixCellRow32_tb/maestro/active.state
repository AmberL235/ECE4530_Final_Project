ADE simulation setup
Test final_proj_pixCellRow32_tb_1: final_proj/pixCellRow32_tb/schematic, simulator spectre
  Models: /opt/cadence-designkits/gpdk045_v_6_0/gpdk045/../models/spectre/gpdk045.scs[mc]
  Variables: VDDL = 1; VDDH = 3.3; W = 120n; Tclk = 10n; Tper = 2n; vwidth = 50n; row_width = 100n; rst_pd = 300n; rst_delay = 0; tx_delay = 100n; tx_pd = 300n; row_pd = 50n; row_delay = 60n; vdd = 1; vrst = 3.3; ibias1 = 1p; ibias2 = 2p; ibias3 = 3p; ibias4 = 5p; ibias5 = 30p; ibias6 = 75p; ibias7 = 1n; ibias8 = 10n; CDi = 100n; Tena = 2n; vdd2 = 3.3; reset = 0; set = 0; tr = 10p; tclk = 15n; Tdelay = 3.5n; rowdelay = 4.5n; TenaRow = 2n
  Temperature: 27.0
  Analysis tran: stop=70n errpreset=conservative
  Analysis dc: (saves the operating point)
Run mode: Single Run, Sweeps and Corners
Setup values for test final_proj_pixCellRow32_tb_1: CDi = 300n
