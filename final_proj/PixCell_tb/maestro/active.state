ADE simulation setup
Test final_proj_PixCell_tb_1: final_proj/PixCell_tb/schematic, simulator spectre
  Models: /opt/cadence-designkits/gpdk045_v_6_0/gpdk045/../models/spectre/gpdk045.scs[mc]
  Variables: vwidth = 5p; row_width = 50p; rst_pd = 50p; rst_delay = 0; tx_delay = 75p; tx_pd = 75p; row_pd = 50p; row_delay = 60p; vdd = 3.3; vrst = 3.3; ibias = 20p:200p:1n
  Temperature: 27.0
  Analysis tran: stop=100p errpreset=conservative
