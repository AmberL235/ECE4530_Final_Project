ADE simulation setup
Run mode: Single Run, Sweeps and Corners
Tests:
  ECE4530_Final_Project_levelshift-test_1: ECE4530_Final_Project/levelshift_unit_test/schematic, simulator spectre
